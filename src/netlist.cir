R1 1 0 100
I1 1 2 2
R2 1 3 300
V1 2 0 1
R3 2 3 400
R4 3 4 600
R5 0 5 400
V2 5 4 5
