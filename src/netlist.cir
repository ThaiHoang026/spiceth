V1 1 0 AC 1 0
R1 1 2 1k
L1 2 3 10m
C1 3 0 1u
