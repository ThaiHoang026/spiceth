R1 1 2 100
C1 2 0 16u
V1 1 0 AC 10
.AC DEC 10 1 1e6
